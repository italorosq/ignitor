* M3 - Q2 S8050 chaveia o GND do modulo rele.
* GATE_1 (GPIO13) -> R6 220 -> base; R5 10k de pull-down.
* Carga: bobina SRD-05VDC (~71,4 ohm + 50 mH) entre 5V_RELE_S e o coletor.
.include ../models/s8050.lib
.include ../models/relay_srd.lib

Vgpio gp 0 PULSE(0 3.3 0.5m 100n 100n 2m 4m)
R6 gp b 220
R5 b 0 10k
Q2 c b 0 S8050
V5 s 0 5
Xcoil s c RELAY_COIL

.tran 0 4m 0 100n
.meas TRAN ib_on AVG I(R6) FROM 1m TO 2m
.meas TRAN ic_on AVG I(V5) FROM 1m TO 2m
.meas TRAN vce_on AVG V(c) FROM 1m TO 2m
.meas TRAN vbe_on AVG V(b) FROM 1m TO 2m
.meas TRAN p_q2 AVG V(c)*abs(Ic(Q2)) FROM 1m TO 2m
.meas TRAN ic_off FIND I(V5) AT 0.2m
.end
