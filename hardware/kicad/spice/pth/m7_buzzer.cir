* M7 - buzzer 5V chaveado por Q3 BC337 (base R3 470 do GPIO14, variante PTH).
.include ../models/bc337.lib
.step param Rb list 80 120 180 250
V5 s 0 5
Rbuz s c {Rb}
Q3 c b 0 BC337
R3 gp b 470
Vgpio gp 0 PULSE(0 3.3 0.5m 1u 1u 1m 2m)
.tran 0 2m 0 1u
.meas TRAN ib AVG I(R3) FROM 1m TO 1.5m
.meas TRAN ic AVG I(V5) FROM 1m TO 1.5m
.meas TRAN vce AVG V(c) FROM 1m TO 1.5m
.meas TRAN p_q3 AVG V(c)*abs(Ic(Q3)) FROM 1m TO 1.5m
.meas TRAN i_gp AVG I(Vgpio) FROM 1m TO 1.5m
.end
